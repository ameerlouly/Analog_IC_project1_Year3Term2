** sch_path: /home/tare/EECE_Projects/Analog_IC_project1/Design/Testbench.sch
**.subckt Testbench
x1 VOUT_LPF net1 GND Idead_opamp
x2 VOUT_HPF net3 GND Idead_opamp
x3 VOUT_BPF net4 GND Idead_opamp
x4 VOUT_BSF net2 GND Idead_opamp
R1 net2 VOUT_BPF 22k m=1
C1 VOUT_BPF net4 16p m=1
R2 net2 VIN 10k m=1
R3 VOUT_BSF net2 10k m=1
R4 net3 VOUT_BSF 10k m=1
R5 net4 VOUT_HPF 10k m=1
R6 net1 VOUT_BPF 10k m=1
R7 net3 VOUT_LPF 10k m=1
R8 VOUT_HPF net3 10k m=1
C2 VOUT_LPF net1 16p m=1
V2 VIN GND SIN(0 1m 1e6 0 0 0)
**** begin user architecture code

.include sim_script_tran.sim

**** end user architecture code
**.ends

* expanding   symbol:  Idead_opamp.sym # of pins=3
** sym_path: /home/tare/EECE_Projects/Analog_IC_project1/Design/Idead_opamp.sym
** sch_path: /home/tare/EECE_Projects/Analog_IC_project1/Design/Idead_opamp.sch
.subckt Idead_opamp VOUT V- V+
*.iopin V-
*.iopin V+
*.iopin VOUT
E1 VOUT1 GND V+ V- 10000
B1 VOUT GND V = max(-1, min(1, V(VOUT1))) m=1
.ends

.GLOBAL GND
.end
